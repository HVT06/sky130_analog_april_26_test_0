* =============================================================
* Full PLL Loop -- Transient Lock Acquisition
* Sky130A PDK  (open_pdks, tt corner)
* =============================================================
* VCO + PFD + CP + Loop Filter + Divider (÷4)
* Reference: 100 MHz → VCO target: 400 MHz
* =============================================================

.title Full PLL Loop Transient -- Sky130A

.param sky130_fd_pr__nfet_01v8__toxe_slope=0
.param sky130_fd_pr__nfet_01v8__vth0_slope=0
.param sky130_fd_pr__nfet_01v8__voff_slope=0
.param sky130_fd_pr__nfet_01v8__toxe_slope1=0
.param sky130_fd_pr__nfet_01v8__vth0_slope1=0
.param sky130_fd_pr__nfet_01v8__voff_slope1=0
.param sky130_fd_pr__pfet_01v8__toxe_slope=0
.param sky130_fd_pr__pfet_01v8__vth0_slope=0
.param sky130_fd_pr__pfet_01v8__voff_slope=0
.param sky130_fd_pr__pfet_01v8__nfactor_slope=0
.param sky130_fd_pr__pfet_01v8__toxe_slope1=0
.param sky130_fd_pr__pfet_01v8__vth0_slope1=0
.param sky130_fd_pr__pfet_01v8__voff_slope1=0
.param sky130_fd_pr__pfet_01v8__nfactor_slope1=0
.param sky130_fd_pr__pfet_01v8__wlod_diff=0
.param sky130_fd_pr__pfet_01v8__kvth0_diff=0
.param sky130_fd_pr__pfet_01v8__lkvth0_diff=0
.param sky130_fd_pr__pfet_01v8__wkvth0_diff=0
.param sky130_fd_pr__pfet_01v8__ku0_diff=0
.param sky130_fd_pr__pfet_01v8__lku0_diff=0
.param sky130_fd_pr__pfet_01v8__wku0_diff=0
.param sky130_fd_pr__pfet_01v8__kvsat_diff=0
.param mc_mm_switch=0
.param mc_pr_switch=0

.include "/home/hvt06/Downloads/open_pdks/sky130/sky130A/libs.ref/sky130_fd_pr/spice/sky130_fd_pr__nfet_01v8__tt.pm3.spice"
.include "/home/hvt06/Downloads/open_pdks/sky130/sky130A/libs.ref/sky130_fd_pr/spice/sky130_fd_pr__pfet_01v8__tt.corner.spice"

Vdd vdd 0 1.8

* ================================================================
* SUBCIRCUIT: Inverter
* ================================================================
.subckt inv in out vdd_l vss_l
XMp vdd_l in out vdd_l sky130_fd_pr__pfet_01v8 l=0.15u w=1.0u
XMn vss_l in out vss_l sky130_fd_pr__nfet_01v8 l=0.15u w=0.5u
.ends inv

* ================================================================
* SUBCIRCUIT: NAND2
* ================================================================
.subckt nand2 a b out vdd_l vss_l
XMp1 vdd_l a   out vdd_l sky130_fd_pr__pfet_01v8 l=0.15u w=1.0u
XMp2 vdd_l b   out vdd_l sky130_fd_pr__pfet_01v8 l=0.15u w=1.0u
XMn1 out   a   mid vss_l sky130_fd_pr__nfet_01v8 l=0.15u w=1.0u
XMn2 mid   b   vss_l vss_l sky130_fd_pr__nfet_01v8 l=0.15u w=1.0u
.ends nand2

* ================================================================
* SUBCIRCUIT: Transmission Gate
* ================================================================
.subckt tgate in out ctrl ctrl_b vdd_l vss_l
XMn in ctrl  out vss_l sky130_fd_pr__nfet_01v8 l=0.15u w=0.84u
XMp in ctrl_b out vdd_l sky130_fd_pr__pfet_01v8 l=0.15u w=1.68u
.ends tgate

* ================================================================
* XSPICE Phase-Frequency Detector (ideal digital logic)
*   Uses XSPICE d_dff + d_and for a correct-by-construction PFD.
*   Analog↔digital bridges interface with transistor-level blocks.
*   Two DFFs (D=1, CLK=ref/div, SET=inactive(0), RESET=AND(UP,DN)).
*   d_dff pinout: data clk set reset out ~out  (set/reset ACTIVE-HIGH)
*   Based on ngspice-45.2/examples/xspice/pll/f-p-det-d-sub.cir
* ================================================================

* Global digital constants
.global d_gnd d_vdd
Vzero_pfd z_pfd 0 dc 0
Vone_pfd one_pfd 0 dc 1.8
abridge_const [z_pfd one_pfd] [d_gnd d_vdd] adc_pfd

* ADC/DAC bridge models for XSPICE PFD
.model adc_pfd adc_bridge(in_low=0.6 in_high=1.2)
.model dac_pfd dac_bridge(out_low=0.0 out_high=1.8 out_undef=0.0)
.model dff_pfd d_dff(clk_delay=1e-10 set_delay=1e-10 reset_delay=1e-10 ic=2 rise_delay=1e-10 fall_delay=1e-10)
.model and_pfd d_and(rise_delay=1e-10 fall_delay=1e-10 input_load=0.5e-12)

* ================================================================
* SUBCIRCUIT: Charge Pump (10µA)
* ================================================================
.subckt charge_pump up dn vout vdd_l vss_l
Xinv_up up up_b vdd_l vss_l inv

* PMOS mirror (Iref sinks from pbias to GND)
XMp_diode pbias pbias vdd_l vdd_l sky130_fd_pr__pfet_01v8 l=1.0u w=4.0u
XMp_mir   ip_src pbias vdd_l vdd_l sky130_fd_pr__pfet_01v8 l=1.0u w=4.0u
XMp_sw    vout   up_b  ip_src vdd_l sky130_fd_pr__pfet_01v8 l=0.15u w=2.0u
Iref_p pbias vss_l 10u

* NMOS mirror (Iref sources from VDD to nbias)
XMn_diode nbias nbias vss_l vss_l sky130_fd_pr__nfet_01v8 l=1.0u w=2.0u
XMn_mir   in_snk nbias vss_l vss_l sky130_fd_pr__nfet_01v8 l=1.0u w=2.0u
XMn_sw    vout   dn   in_snk vss_l sky130_fd_pr__nfet_01v8 l=0.15u w=1.0u
Iref_n vdd_l nbias 10u
.ends charge_pump

* ================================================================
* SUBCIRCUIT: 5-Stage Current-Starved Ring VCO
* ================================================================
.subckt ring_vco vctrl vco_out vdd_l vss_l
* Bias: PMOS diode + NMOS V-to-I
XMp_diode pbias pbias vdd_l vdd_l sky130_fd_pr__pfet_01v8 l=0.5u w=4.0u
XMn_ref   pbias vctrl vss_l vss_l sky130_fd_pr__nfet_01v8 l=0.5u w=2.0u

* Stage 1
XMp_s1 vdd_l pbias  ps1  vdd_l sky130_fd_pr__pfet_01v8 l=0.5u w=4.0u
XMp_i1 ps1   s5     s1   vdd_l sky130_fd_pr__pfet_01v8 l=0.15u w=2.0u
XMn_i1 ns1   s5     s1   vss_l sky130_fd_pr__nfet_01v8 l=0.15u w=1.0u
XMn_k1 vss_l vctrl  ns1  vss_l sky130_fd_pr__nfet_01v8 l=0.5u w=2.0u
Cl1 s1 vss_l 10f

* Stage 2
XMp_s2 vdd_l pbias  ps2  vdd_l sky130_fd_pr__pfet_01v8 l=0.5u w=4.0u
XMp_i2 ps2   s1     s2   vdd_l sky130_fd_pr__pfet_01v8 l=0.15u w=2.0u
XMn_i2 ns2   s1     s2   vss_l sky130_fd_pr__nfet_01v8 l=0.15u w=1.0u
XMn_k2 vss_l vctrl  ns2  vss_l sky130_fd_pr__nfet_01v8 l=0.5u w=2.0u
Cl2 s2 vss_l 10f

* Stage 3
XMp_s3 vdd_l pbias  ps3  vdd_l sky130_fd_pr__pfet_01v8 l=0.5u w=4.0u
XMp_i3 ps3   s2     s3   vdd_l sky130_fd_pr__pfet_01v8 l=0.15u w=2.0u
XMn_i3 ns3   s2     s3   vss_l sky130_fd_pr__nfet_01v8 l=0.15u w=1.0u
XMn_k3 vss_l vctrl  ns3  vss_l sky130_fd_pr__nfet_01v8 l=0.5u w=2.0u
Cl3 s3 vss_l 10f

* Stage 4
XMp_s4 vdd_l pbias  ps4  vdd_l sky130_fd_pr__pfet_01v8 l=0.5u w=4.0u
XMp_i4 ps4   s3     s4   vdd_l sky130_fd_pr__pfet_01v8 l=0.15u w=2.0u
XMn_i4 ns4   s3     s4   vss_l sky130_fd_pr__nfet_01v8 l=0.15u w=1.0u
XMn_k4 vss_l vctrl  ns4  vss_l sky130_fd_pr__nfet_01v8 l=0.5u w=2.0u
Cl4 s4 vss_l 10f

* Stage 5 (output)
XMp_s5 vdd_l pbias  ps5  vdd_l sky130_fd_pr__pfet_01v8 l=0.5u w=4.0u
XMp_i5 ps5   s4     s5   vdd_l sky130_fd_pr__pfet_01v8 l=0.15u w=2.0u
XMn_i5 ns5   s4     s5   vss_l sky130_fd_pr__nfet_01v8 l=0.15u w=1.0u
XMn_k5 vss_l vctrl  ns5  vss_l sky130_fd_pr__nfet_01v8 l=0.5u w=2.0u
Cl5 s5 vss_l 10f

* Output buffer
Xinv_buf1 s5 vco_b vdd_l vss_l inv
Xinv_buf2 vco_b vco_out vdd_l vss_l inv

* Kick-start ring
* Note: .ic inside subcircuit may not work; use top-level .ic with hierarchy
.ends ring_vco

* ================================================================
* SUBCIRCUIT: TG Master-Slave DFF (rising-edge triggered)
* ================================================================
.subckt ms_dff d clk q qb vdd_l vss_l
Xinv_ck clk clk_b vdd_l vss_l inv

* Master latch (transparent when clk=0)
Xtg_m d m_in clk_b clk vdd_l vss_l tgate
Xinv_m1 m_in m_out vdd_l vss_l inv
Xinv_m2 m_out m_in_fb vdd_l vss_l inv
Xtg_mfb m_in_fb m_in clk clk_b vdd_l vss_l tgate

* Slave latch (transparent when clk=1)
Xtg_s m_out s_in clk clk_b vdd_l vss_l tgate
Xinv_s1 s_in q vdd_l vss_l inv
Xinv_s2 q s_in_fb vdd_l vss_l inv
Xtg_sfb s_in_fb s_in clk_b clk vdd_l vss_l tgate

* Qb output
Xinv_qb q qb vdd_l vss_l inv
.ends ms_dff

* ================================================================
* SUBCIRCUIT: Divide-by-2 (toggle DFF)
* ================================================================
.subckt div2 clk out vdd_l vss_l
Xff qb_fb clk q_int qb_fb vdd_l vss_l ms_dff
Xinv_out q_int out vdd_l vss_l inv
.ends div2

* ================================================================
* SUBCIRCUIT: Divide-by-4
* ================================================================
.subckt div4 clk out vdd_l vss_l
Xd1 clk  mid vdd_l vss_l div2
Xd2 mid  out vdd_l vss_l div2
.ends div4

* ================================================================
* Top-Level PLL
* ================================================================

* Reference clock: 100 MHz
Vref ref_clk 0 PULSE(0 1.8 0 0.1n 0.1n 4.9n 10n)

* ---- XSPICE PFD ----
* Analog → Digital bridges for ref and div clocks
abridge_pfd_in [ref_clk div_clk] [ref_d div_d] adc_pfd

* Two DFFs: D=d_vdd, CLK=ref/div, SET=d_gnd(inactive), RESET=rst_d(active-HIGH)
adff_up d_vdd ref_d d_gnd rst_pfd_d up_d nup_d dff_pfd
adff_dn d_vdd div_d d_gnd rst_pfd_d dn_d ndn_d dff_pfd

* Reset = AND(UP,DN) → directly to DFF reset (active-HIGH)
aand_rst [up_d dn_d] rst_pfd_d and_pfd

* Digital → Analog bridges
abridge_pfd_out [up_d dn_d] [up dn] dac_pfd

* Charge Pump
Xcp up dn vctrl vdd 0 charge_pump

* Loop Filter: 2nd-order (R + C1 in series, C2 to ground)
* Kvco ≈ 8.17e9 rad/s/V (1300 MHz/V local), Icp=10µA, N=4
* Target: ω_n = 2π×1MHz, ζ = 1 (critically damped)
* C1 = Kvco·Icp/(N·ω_n²) ≈ 500pF
* R = 2/sqrt(Kvco·Icp·C1/N) ≈ 625Ω
* C2 = C1/10 = 50pF
Rlf vctrl vlf1 625
Clf1 vlf1 0 500p
Clf2 vctrl 0 50p

* VCO
Xvco vctrl vco_out vdd 0 ring_vco

* Feedback divider ÷4 (VCO 400MHz → 100MHz)
Xdiv vco_out div_clk vdd 0 div4

* Initial conditions: Vctrl below lock point to test acquisition from below
.ic v(vctrl)=0.9 v(vlf1)=0.9
* VCO ring kick-start (hierarchical node names)
.ic v(xvco.s1)=1.8 v(xvco.s2)=0 v(xvco.s3)=1.8 v(xvco.s4)=0 v(xvco.s5)=1.8

* ================================================================
* Simulation
* ================================================================
.control
  set filetype=ascii
  set wr_vecnames

  echo "=== Full PLL Loop: Fref=100MHz, N=4, Fvco_target=400MHz ==="
  tran 0.1n 25000n uic

  * Measure Vctrl at various times to track lock acquisition
  meas tran vc_100n  FIND v(vctrl) AT=100n
  meas tran vc_500n  FIND v(vctrl) AT=500n
  meas tran vc_1u    FIND v(vctrl) AT=1000n
  meas tran vc_2u    FIND v(vctrl) AT=2000n
  meas tran vc_3u    FIND v(vctrl) AT=3000n
  meas tran vc_4u    FIND v(vctrl) AT=4000n
  meas tran vc_5u    FIND v(vctrl) AT=5000n
  meas tran vc_6u    FIND v(vctrl) AT=6000n
  meas tran vc_7u    FIND v(vctrl) AT=7000n
  meas tran vc_8u    FIND v(vctrl) AT=8000n
  meas tran vc_9u    FIND v(vctrl) AT=9000n
  meas tran vc_10u   FIND v(vctrl) AT=10000n
  meas tran vc_12u   FIND v(vctrl) AT=12000n
  meas tran vc_15u   FIND v(vctrl) AT=15000n
  meas tran vc_18u   FIND v(vctrl) AT=18000n
  meas tran vc_20u   FIND v(vctrl) AT=20000n
  meas tran vc_22u   FIND v(vctrl) AT=22000n
  meas tran vc_25u   FIND v(vctrl) AT=25000n

  echo ""
  echo "=== Vctrl vs Time ==="
  echo "  100ns: $&vc_100n V"
  echo "  500ns: $&vc_500n V"
  echo "   1us:  $&vc_1u V"
  echo "   2us:  $&vc_2u V"
  echo "   3us:  $&vc_3u V"
  echo "   4us:  $&vc_4u V"
  echo "   5us:  $&vc_5u V"
  echo "   6us:  $&vc_6u V"
  echo "   7us:  $&vc_7u V"
  echo "   8us:  $&vc_8u V"
  echo "   9us:  $&vc_9u V"
  echo "  10us:  $&vc_10u V"
  echo "  12us:  $&vc_12u V"
  echo "  15us:  $&vc_15u V"
  echo "  18us:  $&vc_18u V"
  echo "  20us:  $&vc_20u V"
  echo "  22us:  $&vc_22u V"
  echo "  25us:  $&vc_25u V"

  * Measure VCO frequency near end (~24us mark, ~9600 VCO cycles)
  meas tran tvco_a WHEN v(vco_out)=0.9 RISE=9500
  meas tran tvco_b WHEN v(vco_out)=0.9 RISE=9501
  let fvco = 1e-6 / (tvco_b - tvco_a)
  echo ""
  echo "VCO freq near end = $&fvco MHz (target 400)"

  * Measure divider output frequency near end (~24us, ~2400 div cycles)
  meas tran tdiv_a WHEN v(div_clk)=0.9 RISE=2300
  meas tran tdiv_b WHEN v(div_clk)=0.9 RISE=2301
  let fdiv = 1e-6 / (tdiv_b - tdiv_a)
  echo "DIV freq near end = $&fdiv MHz (target 100)"

  wrdata results/pll_full_tran.tsv v(ref_clk) v(vco_out) v(div_clk) v(vctrl) v(up) v(dn)

  echo ""
  echo "=== Full PLL Simulation Complete ==="
  quit
.endc

.end
