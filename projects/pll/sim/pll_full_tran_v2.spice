* =============================================================
* Full PLL Loop -- Transient Lock Acquisition
* Sky130A PDK  (open_pdks, tt corner)
* =============================================================
* ALL TRANSISTOR-LEVEL (tapeout-ready, no XSPICE)
* VCO + PFD + CP + Loop Filter + Divider (÷4)
* Reference: 100 MHz → VCO target: 400 MHz
*
* Loop filter redesigned for on-chip MOSCAP feasibility:
*   C1 = 10 pF (MOSCAP), C2 = 1 pF (MOSCAP), R = 4.7 kΩ (poly)
*   ωn ≈ 7 MHz, ζ ≈ 0.9, PM ≈ 52°
* =============================================================

.title Full PLL Loop Transient -- Sky130A (Tapeout-Ready)

.param sky130_fd_pr__nfet_01v8__toxe_slope=0
.param sky130_fd_pr__nfet_01v8__vth0_slope=0
.param sky130_fd_pr__nfet_01v8__voff_slope=0
.param sky130_fd_pr__nfet_01v8__toxe_slope1=0
.param sky130_fd_pr__nfet_01v8__vth0_slope1=0
.param sky130_fd_pr__nfet_01v8__voff_slope1=0
.param sky130_fd_pr__pfet_01v8__toxe_slope=0
.param sky130_fd_pr__pfet_01v8__vth0_slope=0
.param sky130_fd_pr__pfet_01v8__voff_slope=0
.param sky130_fd_pr__pfet_01v8__nfactor_slope=0
.param sky130_fd_pr__pfet_01v8__toxe_slope1=0
.param sky130_fd_pr__pfet_01v8__vth0_slope1=0
.param sky130_fd_pr__pfet_01v8__voff_slope1=0
.param sky130_fd_pr__pfet_01v8__nfactor_slope1=0
.param sky130_fd_pr__pfet_01v8__wlod_diff=0
.param sky130_fd_pr__pfet_01v8__kvth0_diff=0
.param sky130_fd_pr__pfet_01v8__lkvth0_diff=0
.param sky130_fd_pr__pfet_01v8__wkvth0_diff=0
.param sky130_fd_pr__pfet_01v8__ku0_diff=0
.param sky130_fd_pr__pfet_01v8__lku0_diff=0
.param sky130_fd_pr__pfet_01v8__wku0_diff=0
.param sky130_fd_pr__pfet_01v8__kvsat_diff=0
.param mc_mm_switch=0
.param mc_pr_switch=0

.include "/home/hvt06/Downloads/open_pdks/sky130/sky130A/libs.ref/sky130_fd_pr/spice/sky130_fd_pr__nfet_01v8__tt.pm3.spice"
.include "/home/hvt06/Downloads/open_pdks/sky130/sky130A/libs.ref/sky130_fd_pr/spice/sky130_fd_pr__pfet_01v8__tt.corner.spice"

Vdd vdd 0 1.8

* ================================================================
* SUBCIRCUIT: Inverter
* ================================================================
.subckt inv in out vdd_l vss_l
XMp vdd_l in out vdd_l sky130_fd_pr__pfet_01v8 l=0.15u w=1.0u
XMn vss_l in out vss_l sky130_fd_pr__nfet_01v8 l=0.15u w=0.5u
.ends inv

* ================================================================
* SUBCIRCUIT: NAND2
* ================================================================
.subckt nand2 a b out vdd_l vss_l
XMp1 vdd_l a   out vdd_l sky130_fd_pr__pfet_01v8 l=0.15u w=1.0u
XMp2 vdd_l b   out vdd_l sky130_fd_pr__pfet_01v8 l=0.15u w=1.0u
XMn1 out   a   mid vss_l sky130_fd_pr__nfet_01v8 l=0.15u w=1.0u
XMn2 mid   b   vss_l vss_l sky130_fd_pr__nfet_01v8 l=0.15u w=1.0u
.ends nand2

* ================================================================
* SUBCIRCUIT: Transmission Gate
* ================================================================
.subckt tgate in out ctrl ctrl_b vdd_l vss_l
XMn in ctrl  out vss_l sky130_fd_pr__nfet_01v8 l=0.15u w=0.84u
XMp in ctrl_b out vdd_l sky130_fd_pr__pfet_01v8 l=0.15u w=1.68u
.ends tgate

* ================================================================
* SUBCIRCUIT: Resettable DFF (active-HIGH asynchronous reset → Q=0)
*   Transmission-gate master-slave with reset overrides.
*   When rst=HIGH: master internal pulled LOW, slave output Q→LOW.
*   All transistor-level — NO XSPICE.
* ================================================================
.subckt dff_reset d clk q qb rst vdd_l vss_l
Xinv_ck   clk   clk_b   vdd_l vss_l inv
Xinv_rst  rst   rst_b   vdd_l vss_l inv

* Master latch (transparent when clk=0)
Xtg_m     d     m_in    clk_b clk   vdd_l vss_l tgate
* Master reset: NMOS pulls m_in→LOW when rst=HIGH → m_out→HIGH
XMn_mrst  m_in  rst     vss_l vss_l sky130_fd_pr__nfet_01v8 l=0.15u w=1.0u
Xinv_m1   m_in  m_out   vdd_l vss_l inv
Xinv_m2   m_out m_in_fb vdd_l vss_l inv
Xtg_mfb   m_in_fb m_in  clk   clk_b vdd_l vss_l tgate

* Slave latch (transparent when clk=1)
Xtg_s     m_out s_in    clk   clk_b vdd_l vss_l tgate
* Slave reset: PMOS pulls s_in→HIGH when rst_b=LOW → q=NOT(HIGH)=LOW
XMp_srst  vdd_l rst_b   s_in  vdd_l sky130_fd_pr__pfet_01v8 l=0.15u w=2.0u
Xinv_s1   s_in  q       vdd_l vss_l inv
Xinv_s2   q     s_in_fb vdd_l vss_l inv
Xtg_sfb   s_in_fb s_in  clk_b clk   vdd_l vss_l tgate

* Qb output
Xinv_qb   q     qb      vdd_l vss_l inv
.ends dff_reset

* ================================================================
* SUBCIRCUIT: Charge Pump (10µA)
* ================================================================
.subckt charge_pump up dn vout vdd_l vss_l
Xinv_up up up_b vdd_l vss_l inv

* PMOS mirror (Iref sinks from pbias to GND)
XMp_diode pbias pbias vdd_l vdd_l sky130_fd_pr__pfet_01v8 l=1.0u w=4.0u
XMp_mir   ip_src pbias vdd_l vdd_l sky130_fd_pr__pfet_01v8 l=1.0u w=4.0u
XMp_sw    vout   up_b  ip_src vdd_l sky130_fd_pr__pfet_01v8 l=0.15u w=2.0u
Iref_p pbias vss_l 10u

* NMOS mirror (Iref sources from VDD to nbias)
XMn_diode nbias nbias vss_l vss_l sky130_fd_pr__nfet_01v8 l=1.0u w=2.0u
XMn_mir   in_snk nbias vss_l vss_l sky130_fd_pr__nfet_01v8 l=1.0u w=2.0u
XMn_sw    vout   dn   in_snk vss_l sky130_fd_pr__nfet_01v8 l=0.15u w=1.0u
Iref_n vdd_l nbias 10u
.ends charge_pump

* ================================================================
* SUBCIRCUIT: 5-Stage Current-Starved Ring VCO
* ================================================================
.subckt ring_vco vctrl vco_out vdd_l vss_l
* Bias: PMOS diode + NMOS V-to-I
XMp_diode pbias pbias vdd_l vdd_l sky130_fd_pr__pfet_01v8 l=0.5u w=4.0u
XMn_ref   pbias vctrl vss_l vss_l sky130_fd_pr__nfet_01v8 l=0.5u w=2.0u

* Stage 1
XMp_s1 vdd_l pbias  ps1  vdd_l sky130_fd_pr__pfet_01v8 l=0.5u w=4.0u
XMp_i1 ps1   s5     s1   vdd_l sky130_fd_pr__pfet_01v8 l=0.15u w=2.0u
XMn_i1 ns1   s5     s1   vss_l sky130_fd_pr__nfet_01v8 l=0.15u w=1.0u
XMn_k1 vss_l vctrl  ns1  vss_l sky130_fd_pr__nfet_01v8 l=0.5u w=2.0u
Cl1 s1 vss_l 10f

* Stage 2
XMp_s2 vdd_l pbias  ps2  vdd_l sky130_fd_pr__pfet_01v8 l=0.5u w=4.0u
XMp_i2 ps2   s1     s2   vdd_l sky130_fd_pr__pfet_01v8 l=0.15u w=2.0u
XMn_i2 ns2   s1     s2   vss_l sky130_fd_pr__nfet_01v8 l=0.15u w=1.0u
XMn_k2 vss_l vctrl  ns2  vss_l sky130_fd_pr__nfet_01v8 l=0.5u w=2.0u
Cl2 s2 vss_l 10f

* Stage 3
XMp_s3 vdd_l pbias  ps3  vdd_l sky130_fd_pr__pfet_01v8 l=0.5u w=4.0u
XMp_i3 ps3   s2     s3   vdd_l sky130_fd_pr__pfet_01v8 l=0.15u w=2.0u
XMn_i3 ns3   s2     s3   vss_l sky130_fd_pr__nfet_01v8 l=0.15u w=1.0u
XMn_k3 vss_l vctrl  ns3  vss_l sky130_fd_pr__nfet_01v8 l=0.5u w=2.0u
Cl3 s3 vss_l 10f

* Stage 4
XMp_s4 vdd_l pbias  ps4  vdd_l sky130_fd_pr__pfet_01v8 l=0.5u w=4.0u
XMp_i4 ps4   s3     s4   vdd_l sky130_fd_pr__pfet_01v8 l=0.15u w=2.0u
XMn_i4 ns4   s3     s4   vss_l sky130_fd_pr__nfet_01v8 l=0.15u w=1.0u
XMn_k4 vss_l vctrl  ns4  vss_l sky130_fd_pr__nfet_01v8 l=0.5u w=2.0u
Cl4 s4 vss_l 10f

* Stage 5 (output)
XMp_s5 vdd_l pbias  ps5  vdd_l sky130_fd_pr__pfet_01v8 l=0.5u w=4.0u
XMp_i5 ps5   s4     s5   vdd_l sky130_fd_pr__pfet_01v8 l=0.15u w=2.0u
XMn_i5 ns5   s4     s5   vss_l sky130_fd_pr__nfet_01v8 l=0.15u w=1.0u
XMn_k5 vss_l vctrl  ns5  vss_l sky130_fd_pr__nfet_01v8 l=0.5u w=2.0u
Cl5 s5 vss_l 10f

* Output buffer
Xinv_buf1 s5 vco_b vdd_l vss_l inv
Xinv_buf2 vco_b vco_out vdd_l vss_l inv
.ends ring_vco

* ================================================================
* SUBCIRCUIT: TG Master-Slave DFF (rising-edge triggered, no reset)
* ================================================================
.subckt ms_dff d clk q qb vdd_l vss_l
Xinv_ck clk clk_b vdd_l vss_l inv

* Master latch (transparent when clk=0)
Xtg_m d m_in clk_b clk vdd_l vss_l tgate
Xinv_m1 m_in m_out vdd_l vss_l inv
Xinv_m2 m_out m_in_fb vdd_l vss_l inv
Xtg_mfb m_in_fb m_in clk clk_b vdd_l vss_l tgate

* Slave latch (transparent when clk=1)
Xtg_s m_out s_in clk clk_b vdd_l vss_l tgate
Xinv_s1 s_in q vdd_l vss_l inv
Xinv_s2 q s_in_fb vdd_l vss_l inv
Xtg_sfb s_in_fb s_in clk_b clk vdd_l vss_l tgate

* Qb output
Xinv_qb q qb vdd_l vss_l inv
.ends ms_dff

* ================================================================
* SUBCIRCUIT: Divide-by-2 (toggle DFF)
* ================================================================
.subckt div2 clk out vdd_l vss_l
Xff qb_fb clk q_int qb_fb vdd_l vss_l ms_dff
Xinv_out q_int out vdd_l vss_l inv
.ends div2

* ================================================================
* SUBCIRCUIT: Divide-by-4
* ================================================================
.subckt div4 clk out vdd_l vss_l
Xd1 clk  mid vdd_l vss_l div2
Xd2 mid  out vdd_l vss_l div2
.ends div4

* ================================================================
* Top-Level PLL (ALL TRANSISTOR-LEVEL)
* ================================================================

* Reference clock: 100 MHz
Vref ref_clk 0 PULSE(0 1.8 0 0.1n 0.1n 4.9n 10n)

* ---- Transistor-Level PFD ----
* Uses dff_reset subcircuit (resettable DFF with TG latches + reset FETs)
Xdff_up  vdd ref_clk up  up_b  pfd_rst vdd 0 dff_reset
Xdff_dn  vdd div_clk dn  dn_b  pfd_rst vdd 0 dff_reset

* Reset = NAND(UP,DN) → inverted to active-HIGH through 3-inverter delay
Xnand_pfd  up  dn  nand_out  vdd 0 nand2
Xinv_pfd1  nand_out  pd1  vdd 0 inv
Xinv_pfd2  pd1       pd2  vdd 0 inv
Xinv_pfd3  pd2       pfd_rst  vdd 0 inv
* When UP=DN=1: NAND=0 → pd1=1 → pd2=0 → pfd_rst=1 (asserts reset) ✓
* Dead-zone delay ≈ 3 × inverter delay ≈ 150 ps

* Charge Pump
Xcp up dn vctrl vdd 0 charge_pump

* Loop Filter: 2nd-order, redesigned for on-chip MOSCAP
* C1 = 10 pF (MOSCAP, 39×42 µm), R = 4.7 kΩ (poly, 20 µm serpentine)
* C2 = 1 pF (MOSCAP, 13×15 µm)
* Loop dynamics: Kvco≈1300MHz/V, Icp=10µA, N=4
*   ωn ≈ 2π×7.2 MHz, ζ ≈ 0.9, PM ≈ 52°
Rlf vctrl vlf1 4700
Clf1 vlf1 0 10p
Clf2 vctrl 0 1p

* VCO
Xvco vctrl vco_out vdd 0 ring_vco

* Feedback divider ÷4 (VCO 400MHz → 100MHz)
Xdiv vco_out div_clk vdd 0 div4

* Initial conditions
.ic v(vctrl)=0.9 v(vlf1)=0.9
.ic v(xvco.s1)=1.8 v(xvco.s2)=0 v(xvco.s3)=1.8 v(xvco.s4)=0 v(xvco.s5)=1.8

* ================================================================
* Simulation
* ================================================================
.control
  set filetype=ascii
  set wr_vecnames

  echo "=== Full PLL (Transistor-Level PFD) ==="
  echo "Fref=100MHz, N=4, Fvco_target=400MHz"
  echo "Loop filter: R=4.7kΩ, C1=10pF, C2=1pF"
  echo ""

  tran 0.1n 15000n uic

  * Track Vctrl over time
  meas tran vc_100n  FIND v(vctrl) AT=100n
  meas tran vc_500n  FIND v(vctrl) AT=500n
  meas tran vc_1u    FIND v(vctrl) AT=1000n
  meas tran vc_2u    FIND v(vctrl) AT=2000n
  meas tran vc_3u    FIND v(vctrl) AT=3000n
  meas tran vc_5u    FIND v(vctrl) AT=5000n
  meas tran vc_7u    FIND v(vctrl) AT=7000n
  meas tran vc_10u   FIND v(vctrl) AT=10000n
  meas tran vc_12u   FIND v(vctrl) AT=12000n
  meas tran vc_15u   FIND v(vctrl) AT=15000n

  echo "=== Vctrl vs Time ==="
  echo "  100ns: $&vc_100n V"
  echo "  500ns: $&vc_500n V"
  echo "   1us:  $&vc_1u V"
  echo "   2us:  $&vc_2u V"
  echo "   3us:  $&vc_3u V"
  echo "   5us:  $&vc_5u V"
  echo "   7us:  $&vc_7u V"
  echo "  10us:  $&vc_10u V"
  echo "  12us:  $&vc_12u V"
  echo "  15us:  $&vc_15u V"

  * Measure VCO frequency near end
  meas tran tvco_a WHEN v(vco_out)=0.9 RISE=5800
  meas tran tvco_b WHEN v(vco_out)=0.9 RISE=5801
  let fvco = 1e-6 / (tvco_b - tvco_a)
  echo ""
  echo "VCO freq near end = $&fvco MHz (target 400)"

  * Save data
  wrdata projects/pll/sim/results/pll_full_tran_v2.tsv v(vctrl) v(vco_out) v(div_clk) v(ref_clk) v(up) v(dn)

  echo ""
  echo "Simulation complete. Data saved."

.endc

.end
