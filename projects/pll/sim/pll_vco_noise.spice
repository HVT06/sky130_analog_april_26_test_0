* =============================================================
* Ring VCO -- Phase Noise Estimation
* Sky130A PDK  (open_pdks, tt corner)
* =============================================================
* Transient noise simulation + Leeson model estimate
* =============================================================

.title Ring VCO Phase Noise Analysis -- Sky130A

.param sky130_fd_pr__nfet_01v8__toxe_slope=0
.param sky130_fd_pr__nfet_01v8__vth0_slope=0
.param sky130_fd_pr__nfet_01v8__voff_slope=0
.param sky130_fd_pr__nfet_01v8__toxe_slope1=0
.param sky130_fd_pr__nfet_01v8__vth0_slope1=0
.param sky130_fd_pr__nfet_01v8__voff_slope1=0
.param sky130_fd_pr__pfet_01v8__toxe_slope=0
.param sky130_fd_pr__pfet_01v8__vth0_slope=0
.param sky130_fd_pr__pfet_01v8__voff_slope=0
.param sky130_fd_pr__pfet_01v8__nfactor_slope=0
.param sky130_fd_pr__pfet_01v8__toxe_slope1=0
.param sky130_fd_pr__pfet_01v8__vth0_slope1=0
.param sky130_fd_pr__pfet_01v8__voff_slope1=0
.param sky130_fd_pr__pfet_01v8__nfactor_slope1=0
.param sky130_fd_pr__pfet_01v8__wlod_diff=0
.param sky130_fd_pr__pfet_01v8__kvth0_diff=0
.param sky130_fd_pr__pfet_01v8__lkvth0_diff=0
.param sky130_fd_pr__pfet_01v8__wkvth0_diff=0
.param sky130_fd_pr__pfet_01v8__ku0_diff=0
.param sky130_fd_pr__pfet_01v8__lku0_diff=0
.param sky130_fd_pr__pfet_01v8__wku0_diff=0
.param sky130_fd_pr__pfet_01v8__kvsat_diff=0
.param mc_mm_switch=0
.param mc_pr_switch=0

.include "/home/hvt06/Downloads/open_pdks/sky130/sky130A/libs.ref/sky130_fd_pr/spice/sky130_fd_pr__nfet_01v8__tt.pm3.spice"
.include "/home/hvt06/Downloads/open_pdks/sky130/sky130A/libs.ref/sky130_fd_pr/spice/sky130_fd_pr__pfet_01v8__tt.corner.spice"

Vdd vdd 0 1.8
Vctrl vctrl 0 1.01

* Bias generation (same as pll_vco_tran)
XMp_diode pbias pbias vdd vdd sky130_fd_pr__pfet_01v8 l=0.5u w=4.0u
XMn_ref   pbias vctrl 0   0   sky130_fd_pr__nfet_01v8 l=0.5u w=2.0u

* 5-stage ring with trnoise voltage sources for noise injection
* Each stage output has a series voltage source with trnoise
* trnoise parameters: Vrms=5mV, timestep=0.02ns (50GHz BW), 1/f_exp=1.0, 1/f_coeff=0.002

* Stage 1
XMp_src1 vdd pbias ps1 vdd sky130_fd_pr__pfet_01v8 l=0.5u w=4.0u
XMp_inv1 ps1 s5    s1i  vdd sky130_fd_pr__pfet_01v8 l=0.15u w=2.0u
XMn_inv1 ns1 s5    s1i  0   sky130_fd_pr__nfet_01v8 l=0.15u w=1.0u
XMn_snk1 0   vctrl ns1 0   sky130_fd_pr__nfet_01v8 l=0.5u w=2.0u
Vn1 s1i s1 dc 0 trnoise 5e-3 0.02n 1.0 0.002

* Stage 2
XMp_src2 vdd pbias ps2 vdd sky130_fd_pr__pfet_01v8 l=0.5u w=4.0u
XMp_inv2 ps2 s1    s2i  vdd sky130_fd_pr__pfet_01v8 l=0.15u w=2.0u
XMn_inv2 ns2 s1    s2i  0   sky130_fd_pr__nfet_01v8 l=0.15u w=1.0u
XMn_snk2 0   vctrl ns2 0   sky130_fd_pr__nfet_01v8 l=0.5u w=2.0u
Vn2 s2i s2 dc 0 trnoise 5e-3 0.02n 1.0 0.002

* Stage 3
XMp_src3 vdd pbias ps3 vdd sky130_fd_pr__pfet_01v8 l=0.5u w=4.0u
XMp_inv3 ps3 s2    s3i  vdd sky130_fd_pr__pfet_01v8 l=0.15u w=2.0u
XMn_inv3 ns3 s2    s3i  0   sky130_fd_pr__nfet_01v8 l=0.15u w=1.0u
XMn_snk3 0   vctrl ns3 0   sky130_fd_pr__nfet_01v8 l=0.5u w=2.0u
Vn3 s3i s3 dc 0 trnoise 5e-3 0.02n 1.0 0.002

* Stage 4
XMp_src4 vdd pbias ps4 vdd sky130_fd_pr__pfet_01v8 l=0.5u w=4.0u
XMp_inv4 ps4 s3    s4i  vdd sky130_fd_pr__pfet_01v8 l=0.15u w=2.0u
XMn_inv4 ns4 s3    s4i  0   sky130_fd_pr__nfet_01v8 l=0.15u w=1.0u
XMn_snk4 0   vctrl ns4 0   sky130_fd_pr__nfet_01v8 l=0.5u w=2.0u
Vn4 s4i s4 dc 0 trnoise 5e-3 0.02n 1.0 0.002

* Stage 5
XMp_src5 vdd pbias ps5 vdd sky130_fd_pr__pfet_01v8 l=0.5u w=4.0u
XMp_inv5 ps5 s4    s5i  vdd sky130_fd_pr__pfet_01v8 l=0.15u w=2.0u
XMn_inv5 ns5 s4    s5i  0   sky130_fd_pr__nfet_01v8 l=0.15u w=1.0u
XMn_snk5 0   vctrl ns5 0   sky130_fd_pr__nfet_01v8 l=0.5u w=2.0u
Vn5 s5i s5 dc 0 trnoise 5e-3 0.02n 1.0 0.002

Cload1 s1 0 10f
Cload2 s2 0 10f
Cload3 s3 0 10f
Cload4 s4 0 10f
Cload5 s5 0 10f

.ic v(s1)=1.8 v(s2)=0 v(s3)=1.8 v(s4)=0 v(s5)=1.8

.control
  set filetype=ascii
  set wr_vecnames

  * Single transient run with trnoise sources active
  * At ~406 MHz, 2000ns ≈ 812 cycles
  tran 0.02n 2000n uic

  wrdata results/pll_vco_noise_tran.tsv v(s5)

  * Measure nominal frequency from first few cycles
  meas tran trise1 WHEN v(s5)=0.9 RISE=5
  meas tran trise2 WHEN v(s5)=0.9 RISE=6
  let period_nom = trise2 - trise1
  let f0 = 1 / period_nom
  let f0_mhz = 1e-6 / period_nom
  echo "=== VCO Frequency ==="
  echo "f0 = $&f0_mhz MHz"
  echo "T0 = $&period_nom s"

  * Measure many consecutive periods for jitter analysis
  echo ""
  echo "=== Period Jitter Measurement ==="
  meas tran t10 WHEN v(s5)=0.9 RISE=10
  meas tran t11 WHEN v(s5)=0.9 RISE=11
  meas tran t12 WHEN v(s5)=0.9 RISE=12
  meas tran t13 WHEN v(s5)=0.9 RISE=13
  meas tran t14 WHEN v(s5)=0.9 RISE=14
  meas tran t15 WHEN v(s5)=0.9 RISE=15
  meas tran t16 WHEN v(s5)=0.9 RISE=16
  meas tran t17 WHEN v(s5)=0.9 RISE=17
  meas tran t18 WHEN v(s5)=0.9 RISE=18
  meas tran t19 WHEN v(s5)=0.9 RISE=19
  meas tran t20 WHEN v(s5)=0.9 RISE=20
  meas tran t30 WHEN v(s5)=0.9 RISE=30
  meas tran t40 WHEN v(s5)=0.9 RISE=40
  meas tran t50 WHEN v(s5)=0.9 RISE=50
  meas tran t100 WHEN v(s5)=0.9 RISE=100
  meas tran t200 WHEN v(s5)=0.9 RISE=200
  meas tran t300 WHEN v(s5)=0.9 RISE=300
  meas tran t400 WHEN v(s5)=0.9 RISE=400
  meas tran t500 WHEN v(s5)=0.9 RISE=500
  meas tran t600 WHEN v(s5)=0.9 RISE=600
  meas tran t700 WHEN v(s5)=0.9 RISE=700
  meas tran t750 WHEN v(s5)=0.9 RISE=750

  * Cycle-to-cycle jitter (consecutive period differences)
  let p1 = t11 - t10
  let p2 = t12 - t11
  let p3 = t13 - t12
  let p4 = t14 - t13
  let p5 = t15 - t14
  let p6 = t16 - t15
  let p7 = t17 - t16
  let p8 = t18 - t17
  let p9 = t19 - t18
  let p10 = t20 - t19

  echo "Period samples (ps):"
  let p1_ps = p1 * 1e12
  let p2_ps = p2 * 1e12
  let p3_ps = p3 * 1e12
  let p4_ps = p4 * 1e12
  let p5_ps = p5 * 1e12
  let p6_ps = p6 * 1e12
  let p7_ps = p7 * 1e12
  let p8_ps = p8 * 1e12
  let p9_ps = p9 * 1e12
  let p10_ps = p10 * 1e12
  echo "  p1=$&p1_ps p2=$&p2_ps p3=$&p3_ps p4=$&p4_ps p5=$&p5_ps"
  echo "  p6=$&p6_ps p7=$&p7_ps p8=$&p8_ps p9=$&p9_ps p10=$&p10_ps"

  let mean_p = (p1+p2+p3+p4+p5+p6+p7+p8+p9+p10)/10
  let mean_p_ps = mean_p * 1e12
  echo "Mean period = $&mean_p_ps ps"

  * Cycle-to-cycle jitter (pk-pk and rms from 10 samples)
  let jit1 = p2 - p1
  let jit2 = p3 - p2
  let jit3 = p4 - p3
  let jit4 = p5 - p4
  let jit5 = p6 - p5
  let jit6 = p7 - p6
  let jit7 = p8 - p7
  let jit8 = p9 - p8
  let jit9 = p10 - p9

  * Long-term accumulated timing (avg period over N cycles)
  let avg_10 = (t20 - t10) / 10
  let avg_100 = (t100 - t10) / 90
  let avg_200 = (t200 - t10) / 190
  let avg_500 = (t500 - t10) / 490
  let avg_700 = (t700 - t10) / 690
  let avg10_ps = avg_10 * 1e12
  let avg100_ps = avg_100 * 1e12
  let avg200_ps = avg_200 * 1e12
  let avg500_ps = avg_500 * 1e12
  let avg700_ps = avg_700 * 1e12
  echo ""
  echo "Average period over N cycles (ps):"
  echo "   10 cycles: $&avg10_ps"
  echo "   90 cycles: $&avg100_ps"
  echo "  190 cycles: $&avg200_ps"
  echo "  490 cycles: $&avg500_ps"
  echo "  690 cycles: $&avg700_ps"

  * Phase drift: long-term accumulated jitter
  * Expected time at cycle N = t10 + N * T0
  * Phase error at cycle N = actual - expected
  let t0_nom = period_nom
  let drift_100 = (t100 - t10) - 90 * t0_nom
  let drift_500 = (t500 - t10) - 490 * t0_nom
  let drift_700 = (t700 - t10) - 690 * t0_nom
  let drift_100_ps = drift_100 * 1e12
  let drift_500_ps = drift_500 * 1e12
  let drift_700_ps = drift_700 * 1e12
  echo ""
  echo "Accumulated phase drift (ps):"
  echo "   90 cycles: $&drift_100_ps"
  echo "  490 cycles: $&drift_500_ps"
  echo "  690 cycles: $&drift_700_ps"

  * Leeson model phase noise estimate
  echo ""
  echo "=== Leeson Model Phase Noise Estimate ==="
  echo "(Analytical, using measured f0)"
  let kT = 1.38e-23 * 300
  let F_noise = 8
  let I_stage = 150e-6
  let Psig = 5 * 1.8 * I_stage
  let Q_ring = 3.14159 * 5 / 2

  let df1M = 1e6
  let ratio1M = f0 / (2 * Q_ring * df1M)
  let L_1M = 10 * log(2 * F_noise * kT / Psig * ratio1M * ratio1M) / log(10)
  echo "L(1 MHz offset) = $&L_1M dBc/Hz"

  let df100k = 1e5
  let ratio100k = f0 / (2 * Q_ring * df100k)
  let L_100k = 10 * log(2 * F_noise * kT / Psig * ratio100k * ratio100k) / log(10)
  echo "L(100 kHz offset) = $&L_100k dBc/Hz"

  let df10M = 1e7
  let ratio10M = f0 / (2 * Q_ring * df10M)
  let L_10M = 10 * log(2 * F_noise * kT / Psig * ratio10M * ratio10M) / log(10)
  echo "L(10 MHz offset) = $&L_10M dBc/Hz"

  echo ""
  echo "=== Phase Noise Analysis Complete ==="
  quit
.endc

.end
