* NGSPICE file created from tt_um_hvt006_tia_flat.ext - technology: sky130A

.subckt tt_um_hvt006_tia_flat VDPWR VGND ua[1] ua[2] ua[3] ua[4] ua[5] ua[6] ua[7]
+ clk ena rst_n ui_in[0] uo_out[0] uio_in[0] uio_out[0] uio_oe[0] ui_in[1] uo_out[1]
+ uio_in[1] uio_out[1] uio_oe[1] ui_in[2] uo_out[2] uio_in[2] uio_out[2] uio_oe[2]
+ ui_in[3] uo_out[3] uio_in[3] uio_out[3] uio_oe[3] ui_in[4] uo_out[4] uio_in[4] uio_out[4]
+ uio_oe[4] ui_in[5] uo_out[5] uio_in[5] uio_out[5] uio_oe[5] ui_in[6] uo_out[6] uio_in[6]
+ uio_out[6] uio_oe[6] ui_in[7] uo_out[7] uio_in[7] uio_out[7] uio_oe[7]
X0 ua[1] ua[1] VDPWR VDPWR sky130_fd_pr__pfet_01v8_hvt ad=0.135 pd=1.27 as=0.135 ps=1.27 w=1 l=0.15
X1 ua[1] ua[1] VGND VGND sky130_fd_pr__nfet_01v8 ad=0.08775 pd=0.92 as=0.247 ps=2.06 w=0.65 l=0.15
X2 VDPWR ua[1] ua[1] VDPWR sky130_fd_pr__pfet_01v8_hvt ad=0.135 pd=1.27 as=0.135 ps=1.27 w=1 l=0.15
X3 ua[1] ua[1] VGND VGND sky130_fd_pr__nfet_01v8 ad=0.08775 pd=0.92 as=0.08775 ps=0.92 w=0.65 l=0.15
X4 VDPWR ua[1] ua[1] VDPWR sky130_fd_pr__pfet_01v8_hvt ad=0.135 pd=1.27 as=0.135 ps=1.27 w=1 l=0.15
X5 VDPWR ua[1] ua[1] VDPWR sky130_fd_pr__pfet_01v8_hvt ad=0.27 pd=2.54 as=0.135 ps=1.27 w=1 l=0.15
X6 ua[1] ua[1] VGND VGND sky130_fd_pr__nfet_01v8 ad=0.08775 pd=0.92 as=0.08775 ps=0.92 w=0.65 l=0.15
X7 ua[1] ua[1] VDPWR VDPWR sky130_fd_pr__pfet_01v8_hvt ad=0.135 pd=1.27 as=0.43 ps=2.86 w=1 l=0.15
X8 VGND ua[1] ua[1] VGND sky130_fd_pr__nfet_01v8 ad=0.08775 pd=0.92 as=0.08775 ps=0.92 w=0.65 l=0.15
X9 ua[1] ua[1] VDPWR VDPWR sky130_fd_pr__pfet_01v8_hvt ad=0.135 pd=1.27 as=0.135 ps=1.27 w=1 l=0.15
X10 VGND ua[1] ua[1] VGND sky130_fd_pr__nfet_01v8 ad=0.08775 pd=0.92 as=0.08775 ps=0.92 w=0.65 l=0.15
X11 VGND ua[1] ua[1] VGND sky130_fd_pr__nfet_01v8 ad=0.1755 pd=1.84 as=0.08775 ps=0.92 w=0.65 l=0.15
.ends
